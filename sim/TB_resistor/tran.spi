*TB_SUN_TR_SKY130NM/TB_NCM
*----------------------------------------------------------------
* Include
*----------------------------------------------------------------
#ifdef Lay
.include ../../../work/lpe/TB_resistor_lpe.spi
#else
.include ../../../work/xsch/TB_resistor.spice
#endif

*-----------------------------------------------------------------
* OPTIONS
*-----------------------------------------------------------------
.option TNOM=27 GMIN=1e-15 reltol=1e-3

*-----------------------------------------------------------------
* PARAMETERS
*-----------------------------------------------------------------
.param TRF = 10p
.param AVDD = {vdda}

*-----------------------------------------------------------------
* FORCE
*-----------------------------------------------------------------
VSS VSS 0   DC 0V
VDD VDD VSS DC {AVDD}

*-----------------------------------------------------------------
* DUT
*-----------------------------------------------------------------
.include ../xdut.spi

*----------------------------------------------------------------
* PROBE
*----------------------------------------------------------------
.save all
.option savecurrents

*----------------------------------------------------------------
* NGSPICE control
*----------------------------------------------------------------
.control
set num_threads=8
set color0=white
set color1=black
unset askquit

optran 0 0 0 1n 1u 0

tran 1n 10n 1p

* set filetype=fast
set filetype=ascii

write {cicname}.raw

* temperature options to choose from:
* -40 -35 -30 -25 -20 -15 -10 -5 0 5 10 15 20 25 30 35 40 45 50 55 60 65 70 75 80 85 90 95 100 105 110 115 120 125
* -40 -20 0 25 50 75 100 125
* -40 -20 0 30 60 90 125
* -40 0 40 80 125
* -40 0 125
* -40 125

foreach circuit_temperature -40 -35 -30 -25 -20 -15 -10 -5 0 5 10 15 20 25 30 35 40 45 50 55 60 65 70 75 80 85 90 95 100 105 110 115 120 125

    reset
    option temp = $circuit_temperature
    echo "Setting simulation temperature to $temp degrees Celsius"

    tran 1n 10n 1p

    write {cicname}_{$circuit_temperature}celsius.raw

    * set wr_singlescale
    * set wr_vecnames
    * option numdgt = 5

    * wrdata {cicname}_{$circuit_temperature}celsius.out
    * + v(vdd) i(vdd)
    * + v(vss) i(vss)

    * + v(xdut.vr)
    * + i(v.xdut.v1)

end

quit

.endc

.end
