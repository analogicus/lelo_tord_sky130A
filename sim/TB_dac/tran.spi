*TB_SUN_TR_SKY130NM/TB_NCM
*----------------------------------------------------------------
* Include
*----------------------------------------------------------------
#ifdef Lay
.include ../../../work/lpe/TB_dac_lpe.spi
#else
.include ../../../work/xsch/TB_dac.spice
#endif

*-----------------------------------------------------------------
* OPTIONS
*-----------------------------------------------------------------
.option TNOM=27 GMIN=1e-15 reltol=1e-3

*-----------------------------------------------------------------
* PARAMETERS
*-----------------------------------------------------------------
.param TRF = 10ps
.param AVDD = {vdda}

.param f_CLK = 2MegHz
.param T_CLK = {1/f_CLK}

.param TD = {T_CLK}
.param TR = {T_CLK/100}
.param TF = {TR}
.param PW = {T_CLK}
.param PER = {T_CLK}

* Time averaging duty cycle is given in percent (%)
.param dutycycle = 35
.param ratio = {dutycycle/100}

* Stepping Current out of DAC
.param step_start = 8us
.param step_length = 2.0us

*-----------------------------------------------------------------
* FORCE
*-----------------------------------------------------------------
VSS   VSS 0   dc 0V
VDD   VDD VSS dc {AVDD}
VSLP  SLP VSS dc 0
VSLPN SLP VSS dc {AVDD}

* VB0  B0   VSS  PULSE({AVDD} 0V {TD} {TR} {TF} {PW*8/16} {PER})
* VB1  B1   VSS  PULSE({AVDD} 0V {TD} {TR} {TF} {PW*9/16} {PER})
* VB2  B2   VSS  PULSE({AVDD} 0V {TD} {TR} {TF} {PW*10/16} {PER})
* VB3  B3   VSS  PULSE({AVDD} 0V {TD} {TR} {TF} {PW*11/16} {PER})
* VB4  B4   VSS  PULSE({AVDD} 0V {TD} {TR} {TF} {PW*12/16} {PER})
* VB5  B5   VSS  PULSE({AVDD} 0V {TD} {TR} {TF} {PW*13/16} {PER})
* VB6  B6   VSS  PULSE({AVDD} 0V {TD} {TR} {TF} {PW*14/16} {PER})
* VB7  B7   VSS  PULSE({AVDD} 0V {TD} {TR} {TF} {PW*15/16} {PER})

VB0  B0   VSS  dc pwl {step_start + 0*step_length} 0V {step_start + 0*step_length + 0.01us} {AVDD}
VB1  B1   VSS  dc pwl {step_start + 1*step_length} 0V {step_start + 1*step_length + 0.01us} {AVDD}
VB2  B2   VSS  dc pwl {step_start + 2*step_length} 0V {step_start + 2*step_length + 0.01us} {AVDD}
VB3  B3   VSS  dc pwl {step_start + 3*step_length} 0V {step_start + 3*step_length + 0.01us} {AVDD}
VB4  B4   VSS  dc pwl {step_start + 4*step_length} 0V {step_start + 4*step_length + 0.01us} {AVDD}
VB5  B5   VSS  dc pwl {step_start + 5*step_length} 0V {step_start + 5*step_length + 0.01us} {AVDD}
VB6  B6   VSS  dc pwl {step_start + 6*step_length} 0V {step_start + 6*step_length + 0.01us} {AVDD}
VB7  B7   VSS  dc pwl {step_start + 7*step_length} 0V {step_start + 7*step_length + 0.01us} {AVDD}

* VBT  BT   VSS  PULSE({AVDD} 0V {2*TD} {TR} {TF} {PW*ratio} {PER})
VBT  BT   VSS  PULSE(0V {AVDD} {2*TD} {TR} {TF} {PW*ratio} {PER})
* VBT  BT   VSS  DC 0V

*-----------------------------------------------------------------
* DUT
*-----------------------------------------------------------------
.include ../xdut.spi
* .include ../svinst.spi

*----------------------------------------------------------------
* PROBE
*----------------------------------------------------------------
.save all
.option savecurrents

*----------------------------------------------------------------
* NGSPICE control
*----------------------------------------------------------------
.control
set num_threads=8
set color0=white
set color1=black
unset askquit

echo "T_CLK = " {T_CLK}

optran 0 0 0 1ns 1us 0

set simulation_length = 25us

tran 1ns $simulation_length 1ps
write

* temperature options to choose from:
* -40 -35 -30 -25 -20 -15 -10 -5 0 5 10 15 20 25 30 35 40 45 50 55 60 65 70 75 80 85 90 95 100 105 110 115 120 125
* -40 -20 0 25 50 75 100 125
* -40 -20 0 30 60 90 125
* -40 0 40 80 125
* -40 0 125
* -40 125

foreach circuit_temperature -40 -35 -30 -25 -20 -15 -10 -5 0 5 10 15 20 25 30 35 40 45 50 55 60 65 70 75 80 85 90 95 100 105 110 115 120 125

    * --- Sleep LOW ---
    alterparam sleep_signal = 0
    alterparam sleep_signal_not = {$vsupply}
    reset
    option temp = {$circuit_temperature}
    set sleep_high_or_low = low

    echo "------------------------------------------------------------"
    echo "view and pvt corner: {cicname}"
    echo "supply voltage: {$vsupply} V"
    echo "circuit temperature: {$temp} C"
    echo "simulation length: {$slenght} ns"
    echo "sleep signal set to: {$sleep_high_or_low}"
    echo "------------------------------------------------------------"

    optran 0 0 0 1ns 1us 0
    tran 1ns {$slenght_ns} 10ps
    write {cicname}_{$temp}celsius_sleep_{$sleep_high_or_low}.raw

    * --- Sleep HIGH ---
    alterparam sleep_signal = {$vsupply}
    alterparam sleep_signal_not = 0
    reset
    option temp = {$circuit_temperature}
    set sleep_high_or_low = high

    echo "------------------------------------------------------------"
    echo "view and pvt corner: {cicname}"
    echo "supply voltage: {$vsupply} V"
    echo "circuit temperature: {$temp} C"
    echo "simulation length: {$slenght} ns"
    echo "sleep signal set to: {$sleep_high_or_low}"
    echo "------------------------------------------------------------"

    optran 0 0 0 1ns 1us 0
    tran 1ns {$slenght_ns} 10ps
    write {cicname}_{$temp}celsius_sleep_{$sleep_high_or_low}.raw

end

quit

.endc

.end
