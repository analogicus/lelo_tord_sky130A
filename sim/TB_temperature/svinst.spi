*Automatic generated instance fron ../../tech/scripts/genxdut tbtemperature
*.include ../../rtl/tbtemperature.v
adut_tbtemperature [clk
+ rst
+ mode
+ cmp_async
+ ]
+ [slp
+ rst_meta
+ reset
+ slp_meta
+ sleep
+ mode_meta
+ operation
+ cmp_meta
+ cmp_sync
+ cmp_rising
+ cmp_falling
+ cmp_rising_counter.7
+ cmp_rising_counter.6
+ cmp_rising_counter.5
+ cmp_rising_counter.4
+ cmp_rising_counter.3
+ cmp_rising_counter.2
+ cmp_rising_counter.1
+ cmp_rising_counter.0
+ cmp_switching_counter.7
+ cmp_switching_counter.6
+ cmp_switching_counter.5
+ cmp_switching_counter.4
+ cmp_switching_counter.3
+ cmp_switching_counter.2
+ cmp_switching_counter.1
+ cmp_switching_counter.0
+ swbrn1
+ swbrn2
+ swbrn3
+ swbgr1
+ swbgr2
+ swcap1
+ swcap2
+ swcap3
+ swdrn1
+ swdrn2
+ swdrn3
+ switch_counter.4
+ switch_counter.3
+ switch_counter.2
+ switch_counter.1
+ switch_counter.0
+ timeout_counter.7
+ timeout_counter.6
+ timeout_counter.5
+ timeout_counter.4
+ timeout_counter.3
+ timeout_counter.2
+ timeout_counter.1
+ timeout_counter.0
+ coarse_step_counter.3
+ coarse_step_counter.2
+ coarse_step_counter.1
+ coarse_step_counter.0
+ coarse_step1.7
+ coarse_step1.6
+ coarse_step1.5
+ coarse_step1.4
+ coarse_step1.3
+ coarse_step1.2
+ coarse_step1.1
+ coarse_step1.0
+ coarse_step2.6
+ coarse_step2.5
+ coarse_step2.4
+ coarse_step2.3
+ coarse_step2.2
+ coarse_step2.1
+ coarse_step2.0
+ finetuning_duty_cycle.7
+ finetuning_duty_cycle.6
+ finetuning_duty_cycle.5
+ finetuning_duty_cycle.4
+ finetuning_duty_cycle.3
+ finetuning_duty_cycle.2
+ finetuning_duty_cycle.1
+ finetuning_duty_cycle.0
+ finetuning_periode.7
+ finetuning_periode.6
+ finetuning_periode.5
+ finetuning_periode.4
+ finetuning_periode.3
+ finetuning_periode.2
+ finetuning_periode.1
+ finetuning_periode.0
+ finetuning_counter.7
+ finetuning_counter.6
+ finetuning_counter.5
+ finetuning_counter.4
+ finetuning_counter.3
+ finetuning_counter.2
+ finetuning_counter.1
+ finetuning_counter.0
+ finetuning_signal
+ saved_coarse_step_counter.3
+ saved_coarse_step_counter.2
+ saved_coarse_step_counter.1
+ saved_coarse_step_counter.0
+ saved_finetuning_duty_cycle.7
+ saved_finetuning_duty_cycle.6
+ saved_finetuning_duty_cycle.5
+ saved_finetuning_duty_cycle.4
+ saved_finetuning_duty_cycle.3
+ saved_finetuning_duty_cycle.2
+ saved_finetuning_duty_cycle.1
+ saved_finetuning_duty_cycle.0
+ saved_finetuning_periode.7
+ saved_finetuning_periode.6
+ saved_finetuning_periode.5
+ saved_finetuning_periode.4
+ saved_finetuning_periode.3
+ saved_finetuning_periode.2
+ saved_finetuning_periode.1
+ saved_finetuning_periode.0
+ stepping_up
+ correct_output_found
+ correct_output_counter.7
+ correct_output_counter.6
+ correct_output_counter.5
+ correct_output_counter.4
+ correct_output_counter.3
+ correct_output_counter.2
+ correct_output_counter.1
+ correct_output_counter.0
+ sleep_counter.7
+ sleep_counter.6
+ sleep_counter.5
+ sleep_counter.4
+ sleep_counter.3
+ sleep_counter.2
+ sleep_counter.1
+ sleep_counter.0
+ ] null dut_tbtemperature
.model dut_tbtemperature d_cosim simulation="../tbtemperature.so" delay=10p

* Inputs
Rsvi_tbtemperature0 clk 0 1G
Rsvi_tbtemperature1 rst 0 1G
Rsvi_tbtemperature2 mode 0 1G
Rsvi_tbtemperature3 cmp_async 0 1G

* Outputs
Rsvi_tbtemperature4 slp 0 1G
Rsvi_tbtemperature5 rst_meta 0 1G
Rsvi_tbtemperature6 reset 0 1G
Rsvi_tbtemperature7 slp_meta 0 1G
Rsvi_tbtemperature8 sleep 0 1G
Rsvi_tbtemperature9 mode_meta 0 1G
Rsvi_tbtemperature10 operation 0 1G
Rsvi_tbtemperature11 cmp_meta 0 1G
Rsvi_tbtemperature12 cmp_sync 0 1G
Rsvi_tbtemperature13 cmp_rising 0 1G
Rsvi_tbtemperature14 cmp_falling 0 1G
Rsvi_tbtemperature15 cmp_rising_counter.7 0 1G
Rsvi_tbtemperature16 cmp_rising_counter.6 0 1G
Rsvi_tbtemperature17 cmp_rising_counter.5 0 1G
Rsvi_tbtemperature18 cmp_rising_counter.4 0 1G
Rsvi_tbtemperature19 cmp_rising_counter.3 0 1G
Rsvi_tbtemperature20 cmp_rising_counter.2 0 1G
Rsvi_tbtemperature21 cmp_rising_counter.1 0 1G
Rsvi_tbtemperature22 cmp_rising_counter.0 0 1G
Rsvi_tbtemperature23 cmp_switching_counter.7 0 1G
Rsvi_tbtemperature24 cmp_switching_counter.6 0 1G
Rsvi_tbtemperature25 cmp_switching_counter.5 0 1G
Rsvi_tbtemperature26 cmp_switching_counter.4 0 1G
Rsvi_tbtemperature27 cmp_switching_counter.3 0 1G
Rsvi_tbtemperature28 cmp_switching_counter.2 0 1G
Rsvi_tbtemperature29 cmp_switching_counter.1 0 1G
Rsvi_tbtemperature30 cmp_switching_counter.0 0 1G
Rsvi_tbtemperature31 swbrn1 0 1G
Rsvi_tbtemperature32 swbrn2 0 1G
Rsvi_tbtemperature33 swbrn3 0 1G
Rsvi_tbtemperature34 swbgr1 0 1G
Rsvi_tbtemperature35 swbgr2 0 1G
Rsvi_tbtemperature36 swcap1 0 1G
Rsvi_tbtemperature37 swcap2 0 1G
Rsvi_tbtemperature38 swcap3 0 1G
Rsvi_tbtemperature39 swdrn1 0 1G
Rsvi_tbtemperature40 swdrn2 0 1G
Rsvi_tbtemperature41 swdrn3 0 1G
Rsvi_tbtemperature42 switch_counter.4 0 1G
Rsvi_tbtemperature43 switch_counter.3 0 1G
Rsvi_tbtemperature44 switch_counter.2 0 1G
Rsvi_tbtemperature45 switch_counter.1 0 1G
Rsvi_tbtemperature46 switch_counter.0 0 1G
Rsvi_tbtemperature47 timeout_counter.7 0 1G
Rsvi_tbtemperature48 timeout_counter.6 0 1G
Rsvi_tbtemperature49 timeout_counter.5 0 1G
Rsvi_tbtemperature50 timeout_counter.4 0 1G
Rsvi_tbtemperature51 timeout_counter.3 0 1G
Rsvi_tbtemperature52 timeout_counter.2 0 1G
Rsvi_tbtemperature53 timeout_counter.1 0 1G
Rsvi_tbtemperature54 timeout_counter.0 0 1G
Rsvi_tbtemperature55 coarse_step_counter.3 0 1G
Rsvi_tbtemperature56 coarse_step_counter.2 0 1G
Rsvi_tbtemperature57 coarse_step_counter.1 0 1G
Rsvi_tbtemperature58 coarse_step_counter.0 0 1G
Rsvi_tbtemperature59 coarse_step1.7 0 1G
Rsvi_tbtemperature60 coarse_step1.6 0 1G
Rsvi_tbtemperature61 coarse_step1.5 0 1G
Rsvi_tbtemperature62 coarse_step1.4 0 1G
Rsvi_tbtemperature63 coarse_step1.3 0 1G
Rsvi_tbtemperature64 coarse_step1.2 0 1G
Rsvi_tbtemperature65 coarse_step1.1 0 1G
Rsvi_tbtemperature66 coarse_step1.0 0 1G
Rsvi_tbtemperature67 coarse_step2.6 0 1G
Rsvi_tbtemperature68 coarse_step2.5 0 1G
Rsvi_tbtemperature69 coarse_step2.4 0 1G
Rsvi_tbtemperature70 coarse_step2.3 0 1G
Rsvi_tbtemperature71 coarse_step2.2 0 1G
Rsvi_tbtemperature72 coarse_step2.1 0 1G
Rsvi_tbtemperature73 coarse_step2.0 0 1G
Rsvi_tbtemperature74 finetuning_duty_cycle.7 0 1G
Rsvi_tbtemperature75 finetuning_duty_cycle.6 0 1G
Rsvi_tbtemperature76 finetuning_duty_cycle.5 0 1G
Rsvi_tbtemperature77 finetuning_duty_cycle.4 0 1G
Rsvi_tbtemperature78 finetuning_duty_cycle.3 0 1G
Rsvi_tbtemperature79 finetuning_duty_cycle.2 0 1G
Rsvi_tbtemperature80 finetuning_duty_cycle.1 0 1G
Rsvi_tbtemperature81 finetuning_duty_cycle.0 0 1G
Rsvi_tbtemperature82 finetuning_periode.7 0 1G
Rsvi_tbtemperature83 finetuning_periode.6 0 1G
Rsvi_tbtemperature84 finetuning_periode.5 0 1G
Rsvi_tbtemperature85 finetuning_periode.4 0 1G
Rsvi_tbtemperature86 finetuning_periode.3 0 1G
Rsvi_tbtemperature87 finetuning_periode.2 0 1G
Rsvi_tbtemperature88 finetuning_periode.1 0 1G
Rsvi_tbtemperature89 finetuning_periode.0 0 1G
Rsvi_tbtemperature90 finetuning_counter.7 0 1G
Rsvi_tbtemperature91 finetuning_counter.6 0 1G
Rsvi_tbtemperature92 finetuning_counter.5 0 1G
Rsvi_tbtemperature93 finetuning_counter.4 0 1G
Rsvi_tbtemperature94 finetuning_counter.3 0 1G
Rsvi_tbtemperature95 finetuning_counter.2 0 1G
Rsvi_tbtemperature96 finetuning_counter.1 0 1G
Rsvi_tbtemperature97 finetuning_counter.0 0 1G
Rsvi_tbtemperature98 finetuning_signal 0 1G
Rsvi_tbtemperature99 saved_coarse_step_counter.3 0 1G
Rsvi_tbtemperature100 saved_coarse_step_counter.2 0 1G
Rsvi_tbtemperature101 saved_coarse_step_counter.1 0 1G
Rsvi_tbtemperature102 saved_coarse_step_counter.0 0 1G
Rsvi_tbtemperature103 saved_finetuning_duty_cycle.7 0 1G
Rsvi_tbtemperature104 saved_finetuning_duty_cycle.6 0 1G
Rsvi_tbtemperature105 saved_finetuning_duty_cycle.5 0 1G
Rsvi_tbtemperature106 saved_finetuning_duty_cycle.4 0 1G
Rsvi_tbtemperature107 saved_finetuning_duty_cycle.3 0 1G
Rsvi_tbtemperature108 saved_finetuning_duty_cycle.2 0 1G
Rsvi_tbtemperature109 saved_finetuning_duty_cycle.1 0 1G
Rsvi_tbtemperature110 saved_finetuning_duty_cycle.0 0 1G
Rsvi_tbtemperature111 saved_finetuning_periode.7 0 1G
Rsvi_tbtemperature112 saved_finetuning_periode.6 0 1G
Rsvi_tbtemperature113 saved_finetuning_periode.5 0 1G
Rsvi_tbtemperature114 saved_finetuning_periode.4 0 1G
Rsvi_tbtemperature115 saved_finetuning_periode.3 0 1G
Rsvi_tbtemperature116 saved_finetuning_periode.2 0 1G
Rsvi_tbtemperature117 saved_finetuning_periode.1 0 1G
Rsvi_tbtemperature118 saved_finetuning_periode.0 0 1G
Rsvi_tbtemperature119 stepping_up 0 1G
Rsvi_tbtemperature120 correct_output_found 0 1G
Rsvi_tbtemperature121 correct_output_counter.7 0 1G
Rsvi_tbtemperature122 correct_output_counter.6 0 1G
Rsvi_tbtemperature123 correct_output_counter.5 0 1G
Rsvi_tbtemperature124 correct_output_counter.4 0 1G
Rsvi_tbtemperature125 correct_output_counter.3 0 1G
Rsvi_tbtemperature126 correct_output_counter.2 0 1G
Rsvi_tbtemperature127 correct_output_counter.1 0 1G
Rsvi_tbtemperature128 correct_output_counter.0 0 1G
Rsvi_tbtemperature129 sleep_counter.7 0 1G
Rsvi_tbtemperature130 sleep_counter.6 0 1G
Rsvi_tbtemperature131 sleep_counter.5 0 1G
Rsvi_tbtemperature132 sleep_counter.4 0 1G
Rsvi_tbtemperature133 sleep_counter.3 0 1G
Rsvi_tbtemperature134 sleep_counter.2 0 1G
Rsvi_tbtemperature135 sleep_counter.1 0 1G
Rsvi_tbtemperature136 sleep_counter.0 0 1G

.save v(slp)

.save v(rst_meta)

.save v(reset)

.save v(slp_meta)

.save v(sleep)

.save v(mode_meta)

.save v(operation)

.save v(cmp_meta)

.save v(cmp_sync)

.save v(cmp_rising)

.save v(cmp_falling)

E_STATE_tbtemperaturecmp_rising_counter dec_cmp_rising_counter 0 value={( 0
+ + 128*v(cmp_rising_counter.7)/AVDD
+ + 64*v(cmp_rising_counter.6)/AVDD
+ + 32*v(cmp_rising_counter.5)/AVDD
+ + 16*v(cmp_rising_counter.4)/AVDD
+ + 8*v(cmp_rising_counter.3)/AVDD
+ + 4*v(cmp_rising_counter.2)/AVDD
+ + 2*v(cmp_rising_counter.1)/AVDD
+ + 1*v(cmp_rising_counter.0)/AVDD
+)/1000}
.save v(dec_cmp_rising_counter)

E_STATE_tbtemperaturecmp_switching_counter dec_cmp_switching_counter 0 value={( 0
+ + 128*v(cmp_switching_counter.7)/AVDD
+ + 64*v(cmp_switching_counter.6)/AVDD
+ + 32*v(cmp_switching_counter.5)/AVDD
+ + 16*v(cmp_switching_counter.4)/AVDD
+ + 8*v(cmp_switching_counter.3)/AVDD
+ + 4*v(cmp_switching_counter.2)/AVDD
+ + 2*v(cmp_switching_counter.1)/AVDD
+ + 1*v(cmp_switching_counter.0)/AVDD
+)/1000}
.save v(dec_cmp_switching_counter)

.save v(swbrn1)

.save v(swbrn2)

.save v(swbrn3)

.save v(swbgr1)

.save v(swbgr2)

.save v(swcap1)

.save v(swcap2)

.save v(swcap3)

.save v(swdrn1)

.save v(swdrn2)

.save v(swdrn3)

E_STATE_tbtemperatureswitch_counter dec_switch_counter 0 value={( 0
+ + 16*v(switch_counter.4)/AVDD
+ + 8*v(switch_counter.3)/AVDD
+ + 4*v(switch_counter.2)/AVDD
+ + 2*v(switch_counter.1)/AVDD
+ + 1*v(switch_counter.0)/AVDD
+)/1000}
.save v(dec_switch_counter)

E_STATE_tbtemperaturetimeout_counter dec_timeout_counter 0 value={( 0
+ + 128*v(timeout_counter.7)/AVDD
+ + 64*v(timeout_counter.6)/AVDD
+ + 32*v(timeout_counter.5)/AVDD
+ + 16*v(timeout_counter.4)/AVDD
+ + 8*v(timeout_counter.3)/AVDD
+ + 4*v(timeout_counter.2)/AVDD
+ + 2*v(timeout_counter.1)/AVDD
+ + 1*v(timeout_counter.0)/AVDD
+)/1000}
.save v(dec_timeout_counter)

E_STATE_tbtemperaturecoarse_step_counter dec_coarse_step_counter 0 value={( 0
+ + 8*v(coarse_step_counter.3)/AVDD
+ + 4*v(coarse_step_counter.2)/AVDD
+ + 2*v(coarse_step_counter.1)/AVDD
+ + 1*v(coarse_step_counter.0)/AVDD
+)/1000}
.save v(dec_coarse_step_counter)

E_STATE_tbtemperaturecoarse_step1 dec_coarse_step1 0 value={( 0
+ + 128*v(coarse_step1.7)/AVDD
+ + 64*v(coarse_step1.6)/AVDD
+ + 32*v(coarse_step1.5)/AVDD
+ + 16*v(coarse_step1.4)/AVDD
+ + 8*v(coarse_step1.3)/AVDD
+ + 4*v(coarse_step1.2)/AVDD
+ + 2*v(coarse_step1.1)/AVDD
+ + 1*v(coarse_step1.0)/AVDD
+)/1000}
.save v(dec_coarse_step1)

E_STATE_tbtemperaturecoarse_step2 dec_coarse_step2 0 value={( 0
+ + 64*v(coarse_step2.6)/AVDD
+ + 32*v(coarse_step2.5)/AVDD
+ + 16*v(coarse_step2.4)/AVDD
+ + 8*v(coarse_step2.3)/AVDD
+ + 4*v(coarse_step2.2)/AVDD
+ + 2*v(coarse_step2.1)/AVDD
+ + 1*v(coarse_step2.0)/AVDD
+)/1000}
.save v(dec_coarse_step2)

E_STATE_tbtemperaturefinetuning_duty_cycle dec_finetuning_duty_cycle 0 value={( 0
+ + 128*v(finetuning_duty_cycle.7)/AVDD
+ + 64*v(finetuning_duty_cycle.6)/AVDD
+ + 32*v(finetuning_duty_cycle.5)/AVDD
+ + 16*v(finetuning_duty_cycle.4)/AVDD
+ + 8*v(finetuning_duty_cycle.3)/AVDD
+ + 4*v(finetuning_duty_cycle.2)/AVDD
+ + 2*v(finetuning_duty_cycle.1)/AVDD
+ + 1*v(finetuning_duty_cycle.0)/AVDD
+)/1000}
.save v(dec_finetuning_duty_cycle)

E_STATE_tbtemperaturefinetuning_periode dec_finetuning_periode 0 value={( 0
+ + 128*v(finetuning_periode.7)/AVDD
+ + 64*v(finetuning_periode.6)/AVDD
+ + 32*v(finetuning_periode.5)/AVDD
+ + 16*v(finetuning_periode.4)/AVDD
+ + 8*v(finetuning_periode.3)/AVDD
+ + 4*v(finetuning_periode.2)/AVDD
+ + 2*v(finetuning_periode.1)/AVDD
+ + 1*v(finetuning_periode.0)/AVDD
+)/1000}
.save v(dec_finetuning_periode)

E_STATE_tbtemperaturefinetuning_counter dec_finetuning_counter 0 value={( 0
+ + 128*v(finetuning_counter.7)/AVDD
+ + 64*v(finetuning_counter.6)/AVDD
+ + 32*v(finetuning_counter.5)/AVDD
+ + 16*v(finetuning_counter.4)/AVDD
+ + 8*v(finetuning_counter.3)/AVDD
+ + 4*v(finetuning_counter.2)/AVDD
+ + 2*v(finetuning_counter.1)/AVDD
+ + 1*v(finetuning_counter.0)/AVDD
+)/1000}
.save v(dec_finetuning_counter)

.save v(finetuning_signal)

E_STATE_tbtemperaturesaved_coarse_step_counter dec_saved_coarse_step_counter 0 value={( 0
+ + 8*v(saved_coarse_step_counter.3)/AVDD
+ + 4*v(saved_coarse_step_counter.2)/AVDD
+ + 2*v(saved_coarse_step_counter.1)/AVDD
+ + 1*v(saved_coarse_step_counter.0)/AVDD
+)/1000}
.save v(dec_saved_coarse_step_counter)

E_STATE_tbtemperaturesaved_finetuning_duty_cycle dec_saved_finetuning_duty_cycle 0 value={( 0
+ + 128*v(saved_finetuning_duty_cycle.7)/AVDD
+ + 64*v(saved_finetuning_duty_cycle.6)/AVDD
+ + 32*v(saved_finetuning_duty_cycle.5)/AVDD
+ + 16*v(saved_finetuning_duty_cycle.4)/AVDD
+ + 8*v(saved_finetuning_duty_cycle.3)/AVDD
+ + 4*v(saved_finetuning_duty_cycle.2)/AVDD
+ + 2*v(saved_finetuning_duty_cycle.1)/AVDD
+ + 1*v(saved_finetuning_duty_cycle.0)/AVDD
+)/1000}
.save v(dec_saved_finetuning_duty_cycle)

E_STATE_tbtemperaturesaved_finetuning_periode dec_saved_finetuning_periode 0 value={( 0
+ + 128*v(saved_finetuning_periode.7)/AVDD
+ + 64*v(saved_finetuning_periode.6)/AVDD
+ + 32*v(saved_finetuning_periode.5)/AVDD
+ + 16*v(saved_finetuning_periode.4)/AVDD
+ + 8*v(saved_finetuning_periode.3)/AVDD
+ + 4*v(saved_finetuning_periode.2)/AVDD
+ + 2*v(saved_finetuning_periode.1)/AVDD
+ + 1*v(saved_finetuning_periode.0)/AVDD
+)/1000}
.save v(dec_saved_finetuning_periode)

.save v(stepping_up)

.save v(correct_output_found)

E_STATE_tbtemperaturecorrect_output_counter dec_correct_output_counter 0 value={( 0
+ + 128*v(correct_output_counter.7)/AVDD
+ + 64*v(correct_output_counter.6)/AVDD
+ + 32*v(correct_output_counter.5)/AVDD
+ + 16*v(correct_output_counter.4)/AVDD
+ + 8*v(correct_output_counter.3)/AVDD
+ + 4*v(correct_output_counter.2)/AVDD
+ + 2*v(correct_output_counter.1)/AVDD
+ + 1*v(correct_output_counter.0)/AVDD
+)/1000}
.save v(dec_correct_output_counter)

E_STATE_tbtemperaturesleep_counter dec_sleep_counter 0 value={( 0
+ + 128*v(sleep_counter.7)/AVDD
+ + 64*v(sleep_counter.6)/AVDD
+ + 32*v(sleep_counter.5)/AVDD
+ + 16*v(sleep_counter.4)/AVDD
+ + 8*v(sleep_counter.3)/AVDD
+ + 4*v(sleep_counter.2)/AVDD
+ + 2*v(sleep_counter.1)/AVDD
+ + 1*v(sleep_counter.0)/AVDD
+)/1000}
.save v(dec_sleep_counter)
