*Automatic generated instance fron ../../tech/scripts/genxdut tbreference
*.include ../../rtl/tbreference.v
adut_tbreference [clk
+ rst
+ slp
+ mode
+ cmp_async
+ ]
+ [rst_meta
+ reset
+ slp_meta
+ sleep
+ mode_meta
+ operation
+ cmp_meta
+ cmp_sync
+ cmp_rising
+ cmp_falling
+ cmp_rising_counter.7
+ cmp_rising_counter.6
+ cmp_rising_counter.5
+ cmp_rising_counter.4
+ cmp_rising_counter.3
+ cmp_rising_counter.2
+ cmp_rising_counter.1
+ cmp_rising_counter.0
+ cmp_switching_counter.7
+ cmp_switching_counter.6
+ cmp_switching_counter.5
+ cmp_switching_counter.4
+ cmp_switching_counter.3
+ cmp_switching_counter.2
+ cmp_switching_counter.1
+ cmp_switching_counter.0
+ swbrn1
+ swbrn2
+ swbrn3
+ swbgr1
+ swbgr2
+ swcap1
+ swcap2
+ swcap3
+ switch_counter.4
+ switch_counter.3
+ switch_counter.2
+ switch_counter.1
+ switch_counter.0
+ timeout_counter.7
+ timeout_counter.6
+ timeout_counter.5
+ timeout_counter.4
+ timeout_counter.3
+ timeout_counter.2
+ timeout_counter.1
+ timeout_counter.0
+ coarse_step_counter.3
+ coarse_step_counter.2
+ coarse_step_counter.1
+ coarse_step_counter.0
+ coarse_step1.7
+ coarse_step1.6
+ coarse_step1.5
+ coarse_step1.4
+ coarse_step1.3
+ coarse_step1.2
+ coarse_step1.1
+ coarse_step1.0
+ coarse_step2.6
+ coarse_step2.5
+ coarse_step2.4
+ coarse_step2.3
+ coarse_step2.2
+ coarse_step2.1
+ coarse_step2.0
+ finetuning_duty_cycle.7
+ finetuning_duty_cycle.6
+ finetuning_duty_cycle.5
+ finetuning_duty_cycle.4
+ finetuning_duty_cycle.3
+ finetuning_duty_cycle.2
+ finetuning_duty_cycle.1
+ finetuning_duty_cycle.0
+ finetuning_periode.7
+ finetuning_periode.6
+ finetuning_periode.5
+ finetuning_periode.4
+ finetuning_periode.3
+ finetuning_periode.2
+ finetuning_periode.1
+ finetuning_periode.0
+ finetuning_counter.7
+ finetuning_counter.6
+ finetuning_counter.5
+ finetuning_counter.4
+ finetuning_counter.3
+ finetuning_counter.2
+ finetuning_counter.1
+ finetuning_counter.0
+ finetuning_signal
+ saved_coarse_step_counter.3
+ saved_coarse_step_counter.2
+ saved_coarse_step_counter.1
+ saved_coarse_step_counter.0
+ saved_finetuning_duty_cycle.7
+ saved_finetuning_duty_cycle.6
+ saved_finetuning_duty_cycle.5
+ saved_finetuning_duty_cycle.4
+ saved_finetuning_duty_cycle.3
+ saved_finetuning_duty_cycle.2
+ saved_finetuning_duty_cycle.1
+ saved_finetuning_duty_cycle.0
+ saved_finetuning_periode.7
+ saved_finetuning_periode.6
+ saved_finetuning_periode.5
+ saved_finetuning_periode.4
+ saved_finetuning_periode.3
+ saved_finetuning_periode.2
+ saved_finetuning_periode.1
+ saved_finetuning_periode.0
+ stepping_up
+ ] null dut_tbreference
.model dut_tbreference d_cosim simulation="../tbreference.so" delay=10p

* Inputs
Rsvi_tbreference0 clk 0 1G
Rsvi_tbreference1 rst 0 1G
Rsvi_tbreference2 slp 0 1G
Rsvi_tbreference3 mode 0 1G
Rsvi_tbreference4 cmp_async 0 1G

* Outputs
Rsvi_tbreference5 rst_meta 0 1G
Rsvi_tbreference6 reset 0 1G
Rsvi_tbreference7 slp_meta 0 1G
Rsvi_tbreference8 sleep 0 1G
Rsvi_tbreference9 mode_meta 0 1G
Rsvi_tbreference10 operation 0 1G
Rsvi_tbreference11 cmp_meta 0 1G
Rsvi_tbreference12 cmp_sync 0 1G
Rsvi_tbreference13 cmp_rising 0 1G
Rsvi_tbreference14 cmp_falling 0 1G
Rsvi_tbreference15 cmp_rising_counter.7 0 1G
Rsvi_tbreference16 cmp_rising_counter.6 0 1G
Rsvi_tbreference17 cmp_rising_counter.5 0 1G
Rsvi_tbreference18 cmp_rising_counter.4 0 1G
Rsvi_tbreference19 cmp_rising_counter.3 0 1G
Rsvi_tbreference20 cmp_rising_counter.2 0 1G
Rsvi_tbreference21 cmp_rising_counter.1 0 1G
Rsvi_tbreference22 cmp_rising_counter.0 0 1G
Rsvi_tbreference23 cmp_switching_counter.7 0 1G
Rsvi_tbreference24 cmp_switching_counter.6 0 1G
Rsvi_tbreference25 cmp_switching_counter.5 0 1G
Rsvi_tbreference26 cmp_switching_counter.4 0 1G
Rsvi_tbreference27 cmp_switching_counter.3 0 1G
Rsvi_tbreference28 cmp_switching_counter.2 0 1G
Rsvi_tbreference29 cmp_switching_counter.1 0 1G
Rsvi_tbreference30 cmp_switching_counter.0 0 1G
Rsvi_tbreference31 swbrn1 0 1G
Rsvi_tbreference32 swbrn2 0 1G
Rsvi_tbreference33 swbrn3 0 1G
Rsvi_tbreference34 swbgr1 0 1G
Rsvi_tbreference35 swbgr2 0 1G
Rsvi_tbreference36 swcap1 0 1G
Rsvi_tbreference37 swcap2 0 1G
Rsvi_tbreference38 swcap3 0 1G
Rsvi_tbreference39 switch_counter.4 0 1G
Rsvi_tbreference40 switch_counter.3 0 1G
Rsvi_tbreference41 switch_counter.2 0 1G
Rsvi_tbreference42 switch_counter.1 0 1G
Rsvi_tbreference43 switch_counter.0 0 1G
Rsvi_tbreference44 timeout_counter.7 0 1G
Rsvi_tbreference45 timeout_counter.6 0 1G
Rsvi_tbreference46 timeout_counter.5 0 1G
Rsvi_tbreference47 timeout_counter.4 0 1G
Rsvi_tbreference48 timeout_counter.3 0 1G
Rsvi_tbreference49 timeout_counter.2 0 1G
Rsvi_tbreference50 timeout_counter.1 0 1G
Rsvi_tbreference51 timeout_counter.0 0 1G
Rsvi_tbreference52 coarse_step_counter.3 0 1G
Rsvi_tbreference53 coarse_step_counter.2 0 1G
Rsvi_tbreference54 coarse_step_counter.1 0 1G
Rsvi_tbreference55 coarse_step_counter.0 0 1G
Rsvi_tbreference56 coarse_step1.7 0 1G
Rsvi_tbreference57 coarse_step1.6 0 1G
Rsvi_tbreference58 coarse_step1.5 0 1G
Rsvi_tbreference59 coarse_step1.4 0 1G
Rsvi_tbreference60 coarse_step1.3 0 1G
Rsvi_tbreference61 coarse_step1.2 0 1G
Rsvi_tbreference62 coarse_step1.1 0 1G
Rsvi_tbreference63 coarse_step1.0 0 1G
Rsvi_tbreference64 coarse_step2.6 0 1G
Rsvi_tbreference65 coarse_step2.5 0 1G
Rsvi_tbreference66 coarse_step2.4 0 1G
Rsvi_tbreference67 coarse_step2.3 0 1G
Rsvi_tbreference68 coarse_step2.2 0 1G
Rsvi_tbreference69 coarse_step2.1 0 1G
Rsvi_tbreference70 coarse_step2.0 0 1G
Rsvi_tbreference71 finetuning_duty_cycle.7 0 1G
Rsvi_tbreference72 finetuning_duty_cycle.6 0 1G
Rsvi_tbreference73 finetuning_duty_cycle.5 0 1G
Rsvi_tbreference74 finetuning_duty_cycle.4 0 1G
Rsvi_tbreference75 finetuning_duty_cycle.3 0 1G
Rsvi_tbreference76 finetuning_duty_cycle.2 0 1G
Rsvi_tbreference77 finetuning_duty_cycle.1 0 1G
Rsvi_tbreference78 finetuning_duty_cycle.0 0 1G
Rsvi_tbreference79 finetuning_periode.7 0 1G
Rsvi_tbreference80 finetuning_periode.6 0 1G
Rsvi_tbreference81 finetuning_periode.5 0 1G
Rsvi_tbreference82 finetuning_periode.4 0 1G
Rsvi_tbreference83 finetuning_periode.3 0 1G
Rsvi_tbreference84 finetuning_periode.2 0 1G
Rsvi_tbreference85 finetuning_periode.1 0 1G
Rsvi_tbreference86 finetuning_periode.0 0 1G
Rsvi_tbreference87 finetuning_counter.7 0 1G
Rsvi_tbreference88 finetuning_counter.6 0 1G
Rsvi_tbreference89 finetuning_counter.5 0 1G
Rsvi_tbreference90 finetuning_counter.4 0 1G
Rsvi_tbreference91 finetuning_counter.3 0 1G
Rsvi_tbreference92 finetuning_counter.2 0 1G
Rsvi_tbreference93 finetuning_counter.1 0 1G
Rsvi_tbreference94 finetuning_counter.0 0 1G
Rsvi_tbreference95 finetuning_signal 0 1G
Rsvi_tbreference96 saved_coarse_step_counter.3 0 1G
Rsvi_tbreference97 saved_coarse_step_counter.2 0 1G
Rsvi_tbreference98 saved_coarse_step_counter.1 0 1G
Rsvi_tbreference99 saved_coarse_step_counter.0 0 1G
Rsvi_tbreference100 saved_finetuning_duty_cycle.7 0 1G
Rsvi_tbreference101 saved_finetuning_duty_cycle.6 0 1G
Rsvi_tbreference102 saved_finetuning_duty_cycle.5 0 1G
Rsvi_tbreference103 saved_finetuning_duty_cycle.4 0 1G
Rsvi_tbreference104 saved_finetuning_duty_cycle.3 0 1G
Rsvi_tbreference105 saved_finetuning_duty_cycle.2 0 1G
Rsvi_tbreference106 saved_finetuning_duty_cycle.1 0 1G
Rsvi_tbreference107 saved_finetuning_duty_cycle.0 0 1G
Rsvi_tbreference108 saved_finetuning_periode.7 0 1G
Rsvi_tbreference109 saved_finetuning_periode.6 0 1G
Rsvi_tbreference110 saved_finetuning_periode.5 0 1G
Rsvi_tbreference111 saved_finetuning_periode.4 0 1G
Rsvi_tbreference112 saved_finetuning_periode.3 0 1G
Rsvi_tbreference113 saved_finetuning_periode.2 0 1G
Rsvi_tbreference114 saved_finetuning_periode.1 0 1G
Rsvi_tbreference115 saved_finetuning_periode.0 0 1G
Rsvi_tbreference116 stepping_up 0 1G

.save v(rst_meta)

.save v(reset)

.save v(slp_meta)

.save v(sleep)

.save v(mode_meta)

.save v(operation)

.save v(cmp_meta)

.save v(cmp_sync)

.save v(cmp_rising)

.save v(cmp_falling)

E_STATE_tbreferencecmp_rising_counter dec_cmp_rising_counter 0 value={( 0
+ + 128*v(cmp_rising_counter.7)/AVDD
+ + 64*v(cmp_rising_counter.6)/AVDD
+ + 32*v(cmp_rising_counter.5)/AVDD
+ + 16*v(cmp_rising_counter.4)/AVDD
+ + 8*v(cmp_rising_counter.3)/AVDD
+ + 4*v(cmp_rising_counter.2)/AVDD
+ + 2*v(cmp_rising_counter.1)/AVDD
+ + 1*v(cmp_rising_counter.0)/AVDD
+)/1000}
.save v(dec_cmp_rising_counter)

E_STATE_tbreferencecmp_switching_counter dec_cmp_switching_counter 0 value={( 0
+ + 128*v(cmp_switching_counter.7)/AVDD
+ + 64*v(cmp_switching_counter.6)/AVDD
+ + 32*v(cmp_switching_counter.5)/AVDD
+ + 16*v(cmp_switching_counter.4)/AVDD
+ + 8*v(cmp_switching_counter.3)/AVDD
+ + 4*v(cmp_switching_counter.2)/AVDD
+ + 2*v(cmp_switching_counter.1)/AVDD
+ + 1*v(cmp_switching_counter.0)/AVDD
+)/1000}
.save v(dec_cmp_switching_counter)

.save v(swbrn1)

.save v(swbrn2)

.save v(swbrn3)

.save v(swbgr1)

.save v(swbgr2)

.save v(swcap1)

.save v(swcap2)

.save v(swcap3)

E_STATE_tbreferenceswitch_counter dec_switch_counter 0 value={( 0
+ + 16*v(switch_counter.4)/AVDD
+ + 8*v(switch_counter.3)/AVDD
+ + 4*v(switch_counter.2)/AVDD
+ + 2*v(switch_counter.1)/AVDD
+ + 1*v(switch_counter.0)/AVDD
+)/1000}
.save v(dec_switch_counter)

E_STATE_tbreferencetimeout_counter dec_timeout_counter 0 value={( 0
+ + 128*v(timeout_counter.7)/AVDD
+ + 64*v(timeout_counter.6)/AVDD
+ + 32*v(timeout_counter.5)/AVDD
+ + 16*v(timeout_counter.4)/AVDD
+ + 8*v(timeout_counter.3)/AVDD
+ + 4*v(timeout_counter.2)/AVDD
+ + 2*v(timeout_counter.1)/AVDD
+ + 1*v(timeout_counter.0)/AVDD
+)/1000}
.save v(dec_timeout_counter)

E_STATE_tbreferencecoarse_step_counter dec_coarse_step_counter 0 value={( 0
+ + 8*v(coarse_step_counter.3)/AVDD
+ + 4*v(coarse_step_counter.2)/AVDD
+ + 2*v(coarse_step_counter.1)/AVDD
+ + 1*v(coarse_step_counter.0)/AVDD
+)/1000}
.save v(dec_coarse_step_counter)

E_STATE_tbreferencecoarse_step1 dec_coarse_step1 0 value={( 0
+ + 128*v(coarse_step1.7)/AVDD
+ + 64*v(coarse_step1.6)/AVDD
+ + 32*v(coarse_step1.5)/AVDD
+ + 16*v(coarse_step1.4)/AVDD
+ + 8*v(coarse_step1.3)/AVDD
+ + 4*v(coarse_step1.2)/AVDD
+ + 2*v(coarse_step1.1)/AVDD
+ + 1*v(coarse_step1.0)/AVDD
+)/1000}
.save v(dec_coarse_step1)

E_STATE_tbreferencecoarse_step2 dec_coarse_step2 0 value={( 0
+ + 64*v(coarse_step2.6)/AVDD
+ + 32*v(coarse_step2.5)/AVDD
+ + 16*v(coarse_step2.4)/AVDD
+ + 8*v(coarse_step2.3)/AVDD
+ + 4*v(coarse_step2.2)/AVDD
+ + 2*v(coarse_step2.1)/AVDD
+ + 1*v(coarse_step2.0)/AVDD
+)/1000}
.save v(dec_coarse_step2)

E_STATE_tbreferencefinetuning_duty_cycle dec_finetuning_duty_cycle 0 value={( 0
+ + 128*v(finetuning_duty_cycle.7)/AVDD
+ + 64*v(finetuning_duty_cycle.6)/AVDD
+ + 32*v(finetuning_duty_cycle.5)/AVDD
+ + 16*v(finetuning_duty_cycle.4)/AVDD
+ + 8*v(finetuning_duty_cycle.3)/AVDD
+ + 4*v(finetuning_duty_cycle.2)/AVDD
+ + 2*v(finetuning_duty_cycle.1)/AVDD
+ + 1*v(finetuning_duty_cycle.0)/AVDD
+)/1000}
.save v(dec_finetuning_duty_cycle)

E_STATE_tbreferencefinetuning_periode dec_finetuning_periode 0 value={( 0
+ + 128*v(finetuning_periode.7)/AVDD
+ + 64*v(finetuning_periode.6)/AVDD
+ + 32*v(finetuning_periode.5)/AVDD
+ + 16*v(finetuning_periode.4)/AVDD
+ + 8*v(finetuning_periode.3)/AVDD
+ + 4*v(finetuning_periode.2)/AVDD
+ + 2*v(finetuning_periode.1)/AVDD
+ + 1*v(finetuning_periode.0)/AVDD
+)/1000}
.save v(dec_finetuning_periode)

E_STATE_tbreferencefinetuning_counter dec_finetuning_counter 0 value={( 0
+ + 128*v(finetuning_counter.7)/AVDD
+ + 64*v(finetuning_counter.6)/AVDD
+ + 32*v(finetuning_counter.5)/AVDD
+ + 16*v(finetuning_counter.4)/AVDD
+ + 8*v(finetuning_counter.3)/AVDD
+ + 4*v(finetuning_counter.2)/AVDD
+ + 2*v(finetuning_counter.1)/AVDD
+ + 1*v(finetuning_counter.0)/AVDD
+)/1000}
.save v(dec_finetuning_counter)

.save v(finetuning_signal)

E_STATE_tbreferencesaved_coarse_step_counter dec_saved_coarse_step_counter 0 value={( 0
+ + 8*v(saved_coarse_step_counter.3)/AVDD
+ + 4*v(saved_coarse_step_counter.2)/AVDD
+ + 2*v(saved_coarse_step_counter.1)/AVDD
+ + 1*v(saved_coarse_step_counter.0)/AVDD
+)/1000}
.save v(dec_saved_coarse_step_counter)

E_STATE_tbreferencesaved_finetuning_duty_cycle dec_saved_finetuning_duty_cycle 0 value={( 0
+ + 128*v(saved_finetuning_duty_cycle.7)/AVDD
+ + 64*v(saved_finetuning_duty_cycle.6)/AVDD
+ + 32*v(saved_finetuning_duty_cycle.5)/AVDD
+ + 16*v(saved_finetuning_duty_cycle.4)/AVDD
+ + 8*v(saved_finetuning_duty_cycle.3)/AVDD
+ + 4*v(saved_finetuning_duty_cycle.2)/AVDD
+ + 2*v(saved_finetuning_duty_cycle.1)/AVDD
+ + 1*v(saved_finetuning_duty_cycle.0)/AVDD
+)/1000}
.save v(dec_saved_finetuning_duty_cycle)

E_STATE_tbreferencesaved_finetuning_periode dec_saved_finetuning_periode 0 value={( 0
+ + 128*v(saved_finetuning_periode.7)/AVDD
+ + 64*v(saved_finetuning_periode.6)/AVDD
+ + 32*v(saved_finetuning_periode.5)/AVDD
+ + 16*v(saved_finetuning_periode.4)/AVDD
+ + 8*v(saved_finetuning_periode.3)/AVDD
+ + 4*v(saved_finetuning_periode.2)/AVDD
+ + 2*v(saved_finetuning_periode.1)/AVDD
+ + 1*v(saved_finetuning_periode.0)/AVDD
+)/1000}
.save v(dec_saved_finetuning_periode)

.save v(stepping_up)
